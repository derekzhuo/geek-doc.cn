Two ideal voltage sources in parallel: singular matrix, timestep too small
V1 1 0 DC 1
V2 1 0 DC 2
R1 1 0 1k
.op
.end
