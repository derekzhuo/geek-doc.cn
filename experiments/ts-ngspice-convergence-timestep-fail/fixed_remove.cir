Fixed: single voltage source, unique solution
V1 1 0 DC 1
R1 1 0 1k
.op
.end
