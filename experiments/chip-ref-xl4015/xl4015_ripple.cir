* XL4015 buck module, open-loop switched behavioral macro, 12 V to 5 V at 2 A
* Datasheet anchors: 180 kHz switching, 5 A cycle current limit, 1.25 V feedback
* reference. Module-level values: L=100 uH, Cout=220 uF with 20 mOhm ESR,
* Schottky freewheel diode Vf~0.5 V (SS54 class).
* Duty 0.442 from the volt-second balance with the 0.54 V freewheel diode
* penalty: D=(Vout+Vd)/(Vin+Vd)=5.54/12.54. PWM edges are 1 ns so edge time
* cannot erode the effective duty at 180 kHz. Open loop by design: this
* macro measures passive steady-state behavior, not feedback transients or
* current-limit trip (limit headroom is checked in xl4015_load_step.cir).
.param fsw=180k d=0.442 ton={d/fsw} tper={1/fsw}
VIN INP 0 12
VPWM PG 0 PULSE(0 5 0 1n 1n {ton-2n} {tper})
S1 INP SW PG 0 swmod
D1 0 SW sch
L1 SW OUT 100u
C1 OUT 0 220u Rser=20m
RL OUT 0 2.5
.model swmod SW(Ron=10m Roff=10Meg Vt=2.5 Vh=0)
.model sch D(Ron=20m Vfwd=0.5 Roff=100Meg)
.tran 0 15m 5m 0.1u
.meas TRAN vavg AVG V(OUT) FROM 8m TO 14m
.meas TRAN vpp PP V(OUT) FROM 8m TO 14m
.meas TRAN ilavg AVG I(L1) FROM 8m TO 14m
.meas TRAN ilmin MIN I(L1) FROM 8m TO 14m
.meas TRAN ilmax MAX I(L1) FROM 8m TO 14m
.meas TRAN iinavg AVG I(VIN) FROM 8m TO 14m
.meas TRAN swmin MIN V(SW) FROM 8m TO 14m
.meas TRAN swmax MAX V(SW) FROM 8m TO 14m
.end
